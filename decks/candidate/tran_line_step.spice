* ldo_ihp_capless x tran_line_step x ihp-sg13g2 x tt -- built by lab.dut.Design
.lib cornerMOSlv.lib mos_tt
.lib cornerRES.lib res_typ
.lib cornerCAP.lib cap_typ
.temp 27

Vdd  vdd 0 pulse(1.4 1.65 1u 100n 100n 10u 20u)
Vss  vss 0 dc 0
Iload vout 0 dc 1m
CLoad vout 0 1p

XDUT vdd vout vss ldo_ihp_capless

.control
  set filetype=ascii
  tran 1n 8u
  meas tran vout_max MAX v(vout) from=1u to=8u
  meas tran vout_min MIN v(vout) from=1u to=8u
  let v_line_pp = vout_max - vout_min
  print v_line_pp
  write
  quit
.endc
.param vref_val=0.6
.param r_w=0.5u
.param r_fb_l=340u
.param c_ff_w=8u
.param r_bias_l=138.5u
.param x_dut_xmb0_w=1u
.param x_dut_xmb0_l=1u
.param x_dut_xmb1_w=1.39u
.param x_dut_xmbp_w=10u
.param x_dut_xmbp_l=1u
.param x_dut_xmt_w=10u
.param x_dut_xm1_w=9.53u
.param x_dut_xm1_l=0.5u
.param x_dut_xm3_w=2.95u
.param x_dut_xm3_l=1u
.param x_dut_xm5_w=2.42u
.param x_dut_xm5_l=0.5u
.param x_dut_xm6_w=5.53u
.param c_comp_w=54u
.param x_dut_xmc_w=15.76u
.param x_dut_xmc_l=0.36u
.param x_dut_xma_w=5.79u
.param x_dut_xma_l=0.5u
.param x_dut_xmcp_w=9.02u
.param x_dut_xmcp_l=0.5u
.param x_dut_xms_w=2.2u
.param x_dut_xms_l=0.95u
.param x_dut_xmp_w=10u
.param x_dut_xmp_l=0.13u
.param x_dut_xmp_m=19
.param c_out_w=58u
.param c_out_m=4
.subckt ldo_ihp_capless vdd vout vss
VREF vref vss dc {vref_val}
VLP lp_brk vout dc 0
XR1 lp_brk fb vss rhigh w=r_w l=r_fb_l
XCFF lp_brk fb cap_cmim w=c_ff_w l=c_ff_w
XR2 fb vss vss rhigh w=r_w l=r_fb_l
XRB vdd nbias vss rhigh w=r_w l=r_bias_l
XMB0 nbias nbias vss vss sg13_lv_nmos l=x_dut_xmb0_l w=x_dut_xmb0_w
XMB1 pbias nbias vss vss sg13_lv_nmos l=x_dut_xmb0_l w=x_dut_xmb1_w
XMBP pbias pbias vdd vdd sg13_lv_pmos l=x_dut_xmbp_l w=x_dut_xmbp_w
XMT ea_tail pbias vdd vdd sg13_lv_pmos l=x_dut_xmbp_l w=x_dut_xmt_w
XM1 ea_n fb ea_tail vdd sg13_lv_pmos l=x_dut_xm1_l w=x_dut_xm1_w
XM2 ea_o1 vref ea_tail vdd sg13_lv_pmos l=x_dut_xm1_l w=x_dut_xm1_w
XM3 ea_n ea_n vss vss sg13_lv_nmos l=x_dut_xm3_l w=x_dut_xm3_w
XM4 ea_o1 ea_n vss vss sg13_lv_nmos l=x_dut_xm3_l w=x_dut_xm3_w
XM5 ea_out ea_o1 vss vss sg13_lv_nmos l=x_dut_xm5_l w=x_dut_xm5_w
XM6 ea_out pbias vdd vdd sg13_lv_pmos l=x_dut_xmbp_l w=x_dut_xm6_w
XCC ea_out ea_o1 cap_cmim w=c_comp_w l=c_comp_w
XMC x1 ea_out vout vdd sg13_lv_pmos l=x_dut_xmc_l w=x_dut_xmc_w
XMA x1 x1 vss vss sg13_lv_nmos l=x_dut_xma_l w=x_dut_xma_w
XMB y x1 vss vss sg13_lv_nmos l=x_dut_xma_l w=x_dut_xma_w
XMCP y y vdd vdd sg13_lv_pmos l=x_dut_xmcp_l w=x_dut_xmcp_w
XMD gate y vdd vdd sg13_lv_pmos l=x_dut_xmcp_l w=x_dut_xmcp_w
XMS gate nbias vss vss sg13_lv_nmos l=x_dut_xms_l w=x_dut_xms_w
XMP vout gate vdd vdd sg13_lv_pmos l=x_dut_xmp_l w=x_dut_xmp_w m=x_dut_xmp_m
XCOUT vout vss cap_cmim w=c_out_w l=c_out_w m=c_out_m
.ends
.end
